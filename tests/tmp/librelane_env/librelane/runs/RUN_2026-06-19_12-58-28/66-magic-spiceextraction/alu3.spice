* NGSPICE file created from alu3.ext - technology: sky130A

* Black-box entry subcircuit for sky130_fd_sc_hd__tapvpwrvgnd_1 abstract view
.subckt sky130_fd_sc_hd__tapvpwrvgnd_1 VGND VPWR
.ends

* Black-box entry subcircuit for sky130_fd_sc_hd__o41a_1 abstract view
.subckt sky130_fd_sc_hd__o41a_1 A1 A2 A3 A4 B1 VGND VNB VPB VPWR X
.ends

* Black-box entry subcircuit for sky130_fd_sc_hd__decap_3 abstract view
.subckt sky130_fd_sc_hd__decap_3 VGND VNB VPB VPWR
.ends

* Black-box entry subcircuit for sky130_fd_sc_hd__or4bb_1 abstract view
.subckt sky130_fd_sc_hd__or4bb_1 A B C_N D_N VGND VNB VPB VPWR X
.ends

* Black-box entry subcircuit for sky130_fd_sc_hd__fill_1 abstract view
.subckt sky130_fd_sc_hd__fill_1 VGND VNB VPB VPWR
.ends

* Black-box entry subcircuit for sky130_fd_sc_hd__and2b_1 abstract view
.subckt sky130_fd_sc_hd__and2b_1 A_N B VGND VNB VPB VPWR X
.ends

* Black-box entry subcircuit for sky130_fd_sc_hd__fill_2 abstract view
.subckt sky130_fd_sc_hd__fill_2 VGND VNB VPB VPWR
.ends

* Black-box entry subcircuit for sky130_fd_sc_hd__decap_4 abstract view
.subckt sky130_fd_sc_hd__decap_4 VGND VNB VPB VPWR
.ends

* Black-box entry subcircuit for sky130_fd_sc_hd__buf_2 abstract view
.subckt sky130_fd_sc_hd__buf_2 A VGND VNB VPB VPWR X
.ends

* Black-box entry subcircuit for sky130_fd_sc_hd__and4_1 abstract view
.subckt sky130_fd_sc_hd__and4_1 A B C D VGND VNB VPB VPWR X
.ends

* Black-box entry subcircuit for sky130_fd_sc_hd__o31a_1 abstract view
.subckt sky130_fd_sc_hd__o31a_1 A1 A2 A3 B1 VGND VNB VPB VPWR X
.ends

* Black-box entry subcircuit for sky130_fd_sc_hd__o21ai_1 abstract view
.subckt sky130_fd_sc_hd__o21ai_1 A1 A2 B1 VGND VNB VPB VPWR Y
.ends

* Black-box entry subcircuit for sky130_fd_sc_hd__a2bb2o_1 abstract view
.subckt sky130_fd_sc_hd__a2bb2o_1 A1_N A2_N B1 B2 VGND VNB VPB VPWR X
.ends

* Black-box entry subcircuit for sky130_fd_sc_hd__inv_2 abstract view
.subckt sky130_fd_sc_hd__inv_2 A VGND VNB VPB VPWR Y
.ends

* Black-box entry subcircuit for sky130_ef_sc_hd__decap_12 abstract view
.subckt sky130_ef_sc_hd__decap_12 VPWR VGND VPB VNB
.ends

* Black-box entry subcircuit for sky130_fd_sc_hd__o221a_1 abstract view
.subckt sky130_fd_sc_hd__o221a_1 A1 A2 B1 B2 C1 VGND VNB VPB VPWR X
.ends

* Black-box entry subcircuit for sky130_fd_sc_hd__o32a_1 abstract view
.subckt sky130_fd_sc_hd__o32a_1 A1 A2 A3 B1 B2 VGND VNB VPB VPWR X
.ends

* Black-box entry subcircuit for sky130_fd_sc_hd__nor2_1 abstract view
.subckt sky130_fd_sc_hd__nor2_1 A B VGND VNB VPB VPWR Y
.ends

* Black-box entry subcircuit for sky130_fd_sc_hd__and3_1 abstract view
.subckt sky130_fd_sc_hd__and3_1 A B C VGND VNB VPB VPWR X
.ends

* Black-box entry subcircuit for sky130_fd_sc_hd__a21o_1 abstract view
.subckt sky130_fd_sc_hd__a21o_1 A1 A2 B1 VGND VNB VPB VPWR X
.ends

* Black-box entry subcircuit for sky130_fd_sc_hd__or2_1 abstract view
.subckt sky130_fd_sc_hd__or2_1 A B VGND VNB VPB VPWR X
.ends

* Black-box entry subcircuit for sky130_fd_sc_hd__decap_6 abstract view
.subckt sky130_fd_sc_hd__decap_6 VGND VNB VPB VPWR
.ends

* Black-box entry subcircuit for sky130_fd_sc_hd__clkbuf_2 abstract view
.subckt sky130_fd_sc_hd__clkbuf_2 A VGND VNB VPB VPWR X
.ends

* Black-box entry subcircuit for sky130_fd_sc_hd__o21ba_1 abstract view
.subckt sky130_fd_sc_hd__o21ba_1 A1 A2 B1_N VGND VNB VPB VPWR X
.ends

* Black-box entry subcircuit for sky130_fd_sc_hd__buf_1 abstract view
.subckt sky130_fd_sc_hd__buf_1 A VGND VNB VPB VPWR X
.ends

* Black-box entry subcircuit for sky130_fd_sc_hd__dlymetal6s2s_1 abstract view
.subckt sky130_fd_sc_hd__dlymetal6s2s_1 A VGND VNB VPB VPWR X
.ends

* Black-box entry subcircuit for sky130_fd_sc_hd__o21a_1 abstract view
.subckt sky130_fd_sc_hd__o21a_1 A1 A2 B1 VGND VNB VPB VPWR X
.ends

* Black-box entry subcircuit for sky130_fd_sc_hd__o22ai_1 abstract view
.subckt sky130_fd_sc_hd__o22ai_1 A1 A2 B1 B2 VGND VNB VPB VPWR Y
.ends

* Black-box entry subcircuit for sky130_fd_sc_hd__nand2b_1 abstract view
.subckt sky130_fd_sc_hd__nand2b_1 A_N B VGND VNB VPB VPWR Y
.ends

* Black-box entry subcircuit for sky130_fd_sc_hd__o22a_1 abstract view
.subckt sky130_fd_sc_hd__o22a_1 A1 A2 B1 B2 VGND VNB VPB VPWR X
.ends

* Black-box entry subcircuit for sky130_fd_sc_hd__or4b_1 abstract view
.subckt sky130_fd_sc_hd__or4b_1 A B C D_N VGND VNB VPB VPWR X
.ends

* Black-box entry subcircuit for sky130_fd_sc_hd__a221o_1 abstract view
.subckt sky130_fd_sc_hd__a221o_1 A1 A2 B1 B2 C1 VGND VNB VPB VPWR X
.ends

* Black-box entry subcircuit for sky130_fd_sc_hd__a21oi_1 abstract view
.subckt sky130_fd_sc_hd__a21oi_1 A1 A2 B1 VGND VNB VPB VPWR Y
.ends

* Black-box entry subcircuit for sky130_fd_sc_hd__or3b_1 abstract view
.subckt sky130_fd_sc_hd__or3b_1 A B C_N VGND VNB VPB VPWR X
.ends

* Black-box entry subcircuit for sky130_fd_sc_hd__decap_8 abstract view
.subckt sky130_fd_sc_hd__decap_8 VGND VNB VPB VPWR
.ends

* Black-box entry subcircuit for sky130_fd_sc_hd__nand2_1 abstract view
.subckt sky130_fd_sc_hd__nand2_1 A B VGND VNB VPB VPWR Y
.ends

* Black-box entry subcircuit for sky130_fd_sc_hd__xnor2_1 abstract view
.subckt sky130_fd_sc_hd__xnor2_1 A B VGND VNB VPB VPWR Y
.ends

.subckt alu3 VGND VPWR i0 i1 i2 i3 i4 i5 i6 i7 i8 i9 o0 o1 o2 o3 o4 o5 o6 o7
XTAP_TAPCELL_ROW_8_22 VGND VPWR sky130_fd_sc_hd__tapvpwrvgnd_1
X_49_ net3 net1 net4 net5 _17_ VGND VGND VPWR VPWR _18_ sky130_fd_sc_hd__o41a_1
XPHY_EDGE_ROW_4_Left_13 VGND VGND VPWR VPWR sky130_fd_sc_hd__decap_3
X_48_ _01_ _05_ _08_ net2 VGND VGND VPWR VPWR _17_ sky130_fd_sc_hd__or4bb_1
XPHY_EDGE_ROW_6_Right_6 VGND VGND VPWR VPWR sky130_fd_sc_hd__decap_3
XFILLER_6_35 VGND VGND VPWR VPWR sky130_fd_sc_hd__decap_3
XFILLER_3_14 VGND VGND VPWR VPWR sky130_fd_sc_hd__fill_1
X_47_ net10 net6 VGND VGND VPWR VPWR _16_ sky130_fd_sc_hd__and2b_1
XFILLER_0_15 VGND VGND VPWR VPWR sky130_fd_sc_hd__fill_2
XFILLER_3_3 VGND VGND VPWR VPWR sky130_fd_sc_hd__decap_4
XFILLER_6_25 VGND VGND VPWR VPWR sky130_fd_sc_hd__decap_3
Xoutput11 net11 VGND VGND VPWR VPWR o0 sky130_fd_sc_hd__buf_2
XFILLER_3_48 VGND VGND VPWR VPWR sky130_fd_sc_hd__fill_1
X_63_ net3 net4 net5 net6 VGND VGND VPWR VPWR net18 sky130_fd_sc_hd__and4_1
XPHY_EDGE_ROW_8_Left_17 VGND VGND VPWR VPWR sky130_fd_sc_hd__decap_3
XFILLER_0_27 VGND VGND VPWR VPWR sky130_fd_sc_hd__fill_1
X_46_ net2 _08_ _15_ _14_ VGND VGND VPWR VPWR net13 sky130_fd_sc_hd__o31a_1
Xoutput12 net12 VGND VGND VPWR VPWR o1 sky130_fd_sc_hd__buf_2
X_29_ net7 net3 VGND VGND VPWR VPWR _01_ sky130_fd_sc_hd__and2b_1
X_62_ net10 _27_ net6 VGND VGND VPWR VPWR net17 sky130_fd_sc_hd__o21ai_1
X_45_ net4 net9 _04_ _09_ VGND VGND VPWR VPWR _15_ sky130_fd_sc_hd__a2bb2o_1
X_28_ net5 VGND VGND VPWR VPWR _00_ sky130_fd_sc_hd__inv_2
Xoutput13 net13 VGND VGND VPWR VPWR o2 sky130_fd_sc_hd__buf_2
XFILLER_3_28 VPWR VGND VPWR VGND sky130_ef_sc_hd__decap_12
X_61_ net4 net9 _10_ net7 net5 VGND VGND VPWR VPWR _27_ sky130_fd_sc_hd__o221a_1
XFILLER_0_29 VPWR VGND VPWR VGND sky130_ef_sc_hd__decap_12
X_44_ net2 _13_ _08_ VGND VGND VPWR VPWR _14_ sky130_fd_sc_hd__o21ai_1
XFILLER_6_17 VGND VGND VPWR VPWR sky130_fd_sc_hd__fill_2
Xoutput14 net14 VGND VGND VPWR VPWR o3 sky130_fd_sc_hd__buf_2
X_60_ _00_ _15_ _19_ _26_ _16_ VGND VGND VPWR VPWR net16 sky130_fd_sc_hd__o32a_1
X_43_ _11_ _12_ VGND VGND VPWR VPWR _13_ sky130_fd_sc_hd__nor2_1
Xoutput15 net15 VGND VGND VPWR VPWR o4 sky130_fd_sc_hd__buf_2
XPHY_EDGE_ROW_1_Right_1 VGND VGND VPWR VPWR sky130_fd_sc_hd__decap_3
XTAP_TAPCELL_ROW_2_19 VGND VPWR sky130_fd_sc_hd__tapvpwrvgnd_1
XFILLER_6_29 VGND VGND VPWR VPWR sky130_fd_sc_hd__decap_3
X_42_ net3 net1 net4 VGND VGND VPWR VPWR _12_ sky130_fd_sc_hd__and3_1
Xoutput16 net16 VGND VGND VPWR VPWR o5 sky130_fd_sc_hd__buf_2
XPHY_EDGE_ROW_3_Left_12 VGND VGND VPWR VPWR sky130_fd_sc_hd__decap_3
X_41_ net7 net4 net8 VGND VGND VPWR VPWR _11_ sky130_fd_sc_hd__a21o_1
Xoutput17 net17 VGND VGND VPWR VPWR o6 sky130_fd_sc_hd__buf_2
XFILLER_7_52 VGND VGND VPWR VPWR sky130_fd_sc_hd__fill_1
X_40_ net8 net9 VGND VGND VPWR VPWR _10_ sky130_fd_sc_hd__or2_1
XFILLER_1_7 VGND VGND VPWR VPWR sky130_fd_sc_hd__decap_6
Xoutput18 net18 VGND VGND VPWR VPWR o7 sky130_fd_sc_hd__buf_2
XPHY_EDGE_ROW_5_Right_5 VGND VGND VPWR VPWR sky130_fd_sc_hd__decap_3
XTAP_TAPCELL_ROW_6_21 VGND VPWR sky130_fd_sc_hd__tapvpwrvgnd_1
XPHY_EDGE_ROW_0_Left_9 VGND VGND VPWR VPWR sky130_fd_sc_hd__decap_3
XPHY_EDGE_ROW_7_Left_16 VGND VGND VPWR VPWR sky130_fd_sc_hd__decap_3
XFILLER_7_22 VGND VGND VPWR VPWR sky130_fd_sc_hd__decap_3
XFILLER_8_3 VPWR VGND VPWR VGND sky130_ef_sc_hd__decap_12
XFILLER_1_13 VGND VGND VPWR VPWR sky130_fd_sc_hd__fill_1
Xinput1 i0 VGND VGND VPWR VPWR net1 sky130_fd_sc_hd__clkbuf_2
Xinput2 i1 VGND VGND VPWR VPWR net2 sky130_fd_sc_hd__clkbuf_2
Xinput3 i2 VGND VGND VPWR VPWR net3 sky130_fd_sc_hd__clkbuf_2
XPHY_EDGE_ROW_0_Right_0 VGND VGND VPWR VPWR sky130_fd_sc_hd__decap_3
Xinput4 i3 VGND VGND VPWR VPWR net4 sky130_fd_sc_hd__clkbuf_2
XFILLER_4_38 VGND VGND VPWR VPWR sky130_fd_sc_hd__decap_4
XFILLER_1_39 VGND VGND VPWR VPWR sky130_fd_sc_hd__fill_1
XPHY_EDGE_ROW_2_Left_11 VGND VGND VPWR VPWR sky130_fd_sc_hd__decap_3
Xinput5 i4 VGND VGND VPWR VPWR net5 sky130_fd_sc_hd__clkbuf_2
X_59_ net9 _24_ net2 VGND VGND VPWR VPWR _26_ sky130_fd_sc_hd__o21ba_1
XFILLER_1_29 VGND VGND VPWR VPWR sky130_fd_sc_hd__decap_4
XTAP_TAPCELL_ROW_0_18 VGND VPWR sky130_fd_sc_hd__tapvpwrvgnd_1
Xinput6 i5 VGND VGND VPWR VPWR net6 sky130_fd_sc_hd__buf_1
X_58_ net10 _25_ VGND VGND VPWR VPWR net15 sky130_fd_sc_hd__or2_1
XPHY_EDGE_ROW_4_Right_4 VGND VGND VPWR VPWR sky130_fd_sc_hd__decap_3
Xinput7 i6 VGND VGND VPWR VPWR net7 sky130_fd_sc_hd__dlymetal6s2s_1
Xinput10 i9 VGND VGND VPWR VPWR net10 sky130_fd_sc_hd__buf_1
X_57_ net9 _24_ net6 VGND VGND VPWR VPWR _25_ sky130_fd_sc_hd__o21a_1
XFILLER_4_19 VGND VGND VPWR VPWR sky130_fd_sc_hd__fill_1
Xinput8 i7 VGND VGND VPWR VPWR net8 sky130_fd_sc_hd__buf_1
XPHY_EDGE_ROW_6_Left_15 VGND VGND VPWR VPWR sky130_fd_sc_hd__decap_3
X_56_ _11_ _12_ net5 VGND VGND VPWR VPWR _24_ sky130_fd_sc_hd__o21a_1
X_39_ net8 net9 VGND VGND VPWR VPWR _09_ sky130_fd_sc_hd__nor2_1
XFILLER_5_41 VGND VGND VPWR VPWR sky130_fd_sc_hd__fill_2
Xinput9 i8 VGND VGND VPWR VPWR net9 sky130_fd_sc_hd__clkbuf_2
X_55_ _16_ _18_ _19_ _23_ VGND VGND VPWR VPWR net14 sky130_fd_sc_hd__o22ai_1
XTAP_TAPCELL_ROW_4_20 VGND VPWR sky130_fd_sc_hd__tapvpwrvgnd_1
X_38_ net9 net5 VGND VGND VPWR VPWR _08_ sky130_fd_sc_hd__nand2b_1
XPHY_EDGE_ROW_8_Right_8 VGND VGND VPWR VPWR sky130_fd_sc_hd__decap_3
X_54_ _20_ _21_ _22_ net7 VGND VGND VPWR VPWR _23_ sky130_fd_sc_hd__o22a_1
X_37_ net2 _04_ _05_ _07_ VGND VGND VPWR VPWR net12 sky130_fd_sc_hd__o31a_1
X_53_ net8 _03_ _08_ net4 VGND VGND VPWR VPWR _22_ sky130_fd_sc_hd__or4b_1
X_36_ net2 _06_ _05_ VGND VGND VPWR VPWR _07_ sky130_fd_sc_hd__o21ai_1
XFILLER_5_33 VGND VGND VPWR VPWR sky130_fd_sc_hd__decap_3
X_52_ net4 net9 _10_ net3 net1 VGND VGND VPWR VPWR _21_ sky130_fd_sc_hd__a221o_1
X_35_ net3 net1 net7 VGND VGND VPWR VPWR _06_ sky130_fd_sc_hd__a21oi_1
XPHY_EDGE_ROW_1_Left_10 VGND VGND VPWR VPWR sky130_fd_sc_hd__decap_3
XFILLER_2_6 VGND VGND VPWR VPWR sky130_fd_sc_hd__decap_6
X_51_ net5 _11_ net9 VGND VGND VPWR VPWR _20_ sky130_fd_sc_hd__a21oi_1
XFILLER_0_3 VPWR VGND VPWR VGND sky130_ef_sc_hd__decap_12
X_34_ net8 net4 VGND VGND VPWR VPWR _05_ sky130_fd_sc_hd__and2b_1
XFILLER_2_25 VGND VGND VPWR VPWR sky130_fd_sc_hd__decap_3
X_33_ net7 net1 net3 VGND VGND VPWR VPWR _04_ sky130_fd_sc_hd__o21ai_1
XFILLER_2_47 VGND VGND VPWR VPWR sky130_fd_sc_hd__fill_2
X_50_ net2 net10 net6 VGND VGND VPWR VPWR _19_ sky130_fd_sc_hd__or3b_1
XFILLER_8_35 VGND VGND VPWR VPWR sky130_fd_sc_hd__decap_8
XPHY_EDGE_ROW_3_Right_3 VGND VGND VPWR VPWR sky130_fd_sc_hd__decap_3
XFILLER_5_47 VGND VGND VPWR VPWR sky130_fd_sc_hd__fill_2
X_32_ net3 net1 VGND VGND VPWR VPWR _03_ sky130_fd_sc_hd__nand2_1
X_31_ _01_ _02_ VGND VGND VPWR VPWR net11 sky130_fd_sc_hd__xnor2_1
XFILLER_8_15 VPWR VGND VPWR VGND sky130_ef_sc_hd__decap_12
XPHY_EDGE_ROW_5_Left_14 VGND VGND VPWR VPWR sky130_fd_sc_hd__decap_3
XFILLER_8_27 VGND VGND VPWR VPWR sky130_fd_sc_hd__fill_1
X_30_ net2 net1 VGND VGND VPWR VPWR _02_ sky130_fd_sc_hd__and2b_1
XPHY_EDGE_ROW_7_Right_7 VGND VGND VPWR VPWR sky130_fd_sc_hd__decap_3
XFILLER_3_40 VGND VGND VPWR VPWR sky130_fd_sc_hd__decap_8
XFILLER_8_29 VGND VGND VPWR VPWR sky130_fd_sc_hd__fill_2
XFILLER_6_51 VGND VGND VPWR VPWR sky130_fd_sc_hd__fill_2
XFILLER_7_3 VGND VGND VPWR VPWR sky130_fd_sc_hd__decap_3
XFILLER_0_21 VGND VGND VPWR VPWR sky130_fd_sc_hd__decap_6
XFILLER_3_10 VGND VGND VPWR VPWR sky130_fd_sc_hd__decap_4
XPHY_EDGE_ROW_2_Right_2 VGND VGND VPWR VPWR sky130_fd_sc_hd__decap_3
XFILLER_5_3 VGND VGND VPWR VPWR sky130_fd_sc_hd__fill_2
XFILLER_6_11 VGND VGND VPWR VPWR sky130_fd_sc_hd__decap_3
.ends
